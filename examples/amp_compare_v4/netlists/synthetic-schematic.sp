* Synthetic topology only; not a foundry model or a simulation result.
.subckt amp_compare_v4 VINP VINN VOUT VDD VSS IBIAS
MNREF IBIAS IBIAS VSS VSS TOY_NMOS W=12u L=1u M=2
MNTAIL TAIL IBIAS VSS VSS TOY_NMOS W=12u L=1u M=2
MNSINK VOUT IBIAS VSS VSS TOY_NMOS W=12u L=1u M=2
MNIP N1 VINP TAIL VSS TOY_NMOS W=16u L=1u M=2
MNIN N2 VINN TAIL VSS TOY_NMOS W=16u L=1u M=2
MPREF N2 N2 VDD VDD TOY_PMOS W=12u L=1u M=2
MPLOAD N1 N2 VDD VDD TOY_PMOS W=12u L=1u M=2
MPDRIVE VOUT N1 VDD VDD TOY_PMOS W=16u L=1u M=4
MND_BIAS VSS VSS VSS VSS TOY_NMOS W=12u L=1u M=2
MND_INPUT VSS VSS VSS VSS TOY_NMOS W=16u L=1u M=2
MPD_LOAD VDD VDD VDD VDD TOY_PMOS W=12u L=1u M=2
MPD_OUTPUT VDD VDD VDD VDD TOY_PMOS W=16u L=1u M=4
CCCOMP N1 VOUT 200f
.ends amp_compare_v4
* TOY model identifiers are intentionally undefined; this file is a connectivity illustration.
